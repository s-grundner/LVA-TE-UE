** sch_path: /foss/designs/a1_k12136610.sch
**.subckt a1_k12136610 out
*.opin out
XM1 out in net2 net2 sky130_fd_pr__pfet_01v8 L=0.15 W=1 nf=1 ad=0.29 as=0.29 pd=2.58 ps=2.58 nrd=0.29 nrs=0.29 sa=0 sb=0 sd=0
+ mult=1 m=1
VIN in GND 1.8
VDD net2 GND 1.8
R1 net1 GND 50k m=1
VOUT out net1 0
**** begin user architecture code

.lib /foss/pdks/sky130A/libs.tech/ngspice/sky130.lib.spice tt

.op
.dc VIN 0 1.8 1m
.ac dec 100 10 14G
.tran 1n 200n 1G

.save all

**** end user architecture code
**.ends
.GLOBAL GND
.end
